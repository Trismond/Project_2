ADE simulation setup
Run mode: Single Run, Sweeps and Corners
Tests:
  Project_2_ADDER_TB_1: Project_2/ADDER_1_TB/schematic, simulator spectre
    Outputs: /Carry_OUT; /S1; /S0; "/B1"; /B1; /B0; /A1; /A0; /Carry_IN
