ADE simulation setup
Test Project_2_ADDER_TB_1: Project_2/ADDER_1_TB/schematic, simulator spectre
  Models: /opt/pdk/gpdk045/gpdk045_v_6_0/gpdk045/../models/spectre/gpdk045.scs[mc]
  Temperature: 27
  Analysis tran: stop=160n
  Signals: /Carry_OUT, /S1, /S0, /B1, /B0, /A1, /A0, /Carry_IN
Run mode: Single Run, Sweeps and Corners
