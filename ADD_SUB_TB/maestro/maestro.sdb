ADE simulation setup
Run mode: Single Run, Sweeps and Corners
Tests:
  Project_2_SUB_TB_1: Project_2/ADD_SUB_TB/schematic, simulator spectre
    Outputs: "/S3"; "/S2"; "/S1"; "/B1"; "/C_I"; /S3; /S2; /S1; /S0; /A1; /A0; /B1; /B0; /C_I
