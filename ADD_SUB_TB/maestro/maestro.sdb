ADE simulation setup
Run mode: Single Run, Sweeps and Corners
Tests:
  Project_2_SUB_TB_1: Project_2/ADD_SUB_TB/schematic, simulator spectre
    Outputs: /B_Out; /D1; /D0; /A1; "/B1"; /B1; /A0; /B0; /B_In
