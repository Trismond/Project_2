ADE simulation setup
Test Project_2_SUB_TB_1: Project_2/ADD_SUB_TB/schematic, simulator spectre
  Models: /opt/pdk/gpdk045/gpdk045_v_6_0/gpdk045/../models/spectre/gpdk045.scs[mc]
  Temperature: 27
  Analysis tran: stop=160n
  Signals: /S3, /S2, /S1, /S0, /A1, /A0, /B1, /B0, /C_I
Run mode: Single Run, Sweeps and Corners
