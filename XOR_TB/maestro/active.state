ADE simulation setup
Test Project_2_XOR_TB_1: Project_2/XOR_TB/schematic, simulator spectre
  Models: /opt/pdk/gpdk045/gpdk045_v_6_0/gpdk045/../models/spectre/gpdk045.scs[mc]
  Temperature: 27
  Analysis tran: stop=40n
  Signals: /OUT, /A, /B
Run mode: Single Run, Sweeps and Corners
