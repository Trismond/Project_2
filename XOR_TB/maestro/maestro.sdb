ADE simulation setup
Run mode: Single Run, Sweeps and Corners
Tests:
  Project_2_XOR_TB_1: Project_2/XOR_TB/schematic, simulator spectre
    Outputs: /OUT; /A; /B
