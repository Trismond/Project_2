ADE simulation setup
Test Project_2_3_input_and_tb_1: Project_2/3_input_and_tb/schematic, simulator spectre
  Models: /opt/pdk/gpdk045/gpdk045_v_6_0/gpdk045/../models/spectre/gpdk045.scs[mc]
  Temperature: 27
  Analysis tran: stop=120n
  Signals: /in1, /in2, /in3, /Vout
Run mode: Single Run, Sweeps and Corners
