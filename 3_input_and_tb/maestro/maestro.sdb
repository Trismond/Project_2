ADE simulation setup
Run mode: Single Run, Sweeps and Corners
Tests:
  Project_2_3_input_and_tb_1: Project_2/3_input_and_tb/schematic, simulator spectre
