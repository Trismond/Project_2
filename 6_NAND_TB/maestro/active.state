ADE simulation setup
Test Project_2_6_NAND_TB_1: Project_2/6_NAND_TB/schematic, simulator spectre
  Models: /opt/pdk/gpdk045/gpdk045_v_6_0/gpdk045/../models/spectre/gpdk045.scs[mc]
  Temperature: 27
  Analysis tran: stop=640n
  Signals: /A0, /A1, /A2, /A3, /A4, /A5, /OUT
Run mode: Single Run, Sweeps and Corners
