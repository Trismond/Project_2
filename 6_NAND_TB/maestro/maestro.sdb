ADE simulation setup
Run mode: Single Run, Sweeps and Corners
Tests:
  Project_2_6_NAND_TB_1: Project_2/6_NAND_TB/schematic, simulator spectre
    Outputs: /A0; /A1; /A2; /A3; /A4; /A5; /OUT
