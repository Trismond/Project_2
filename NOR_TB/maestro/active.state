ADE simulation setup
Test Project_1_NOR_TB_1: Project_1/NOR_TB/schematic, simulator spectre
  Models: /opt/pdk/gpdk045/gpdk045_v_6_0/gpdk045/../models/spectre/gpdk045.scs[mc]
  Temperature: 27
  Analysis tran: stop=40n
  Signals: /Out as OUT, /In_A as IN_A, /In_B as IN_B
Run mode: Single Run, Sweeps and Corners
