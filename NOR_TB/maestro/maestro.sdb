ADE simulation setup
Run mode: Single Run, Sweeps and Corners
Tests:
  Project_1_NOR_TB_1: Project_1/NOR_TB/schematic, simulator spectre
    Outputs: OUT; IN_A; IN_B
