ADE simulation setup
Test Project_2_FA_TB_1: Project_2/FA_TB/schematic, simulator spectre
  Models: /opt/pdk/gpdk045/gpdk045_v_6_0/gpdk045/../models/spectre/gpdk045.scs[mc]
  Temperature: 27
  Analysis tran: stop=80n
  Signals: /Carry_OUT, /SUM, /Carry_IN, /B, /A
Run mode: Single Run, Sweeps and Corners
