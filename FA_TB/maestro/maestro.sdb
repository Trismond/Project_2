ADE simulation setup
Run mode: Single Run, Sweeps and Corners
Tests:
  Project_2_FA_TB_1: Project_2/FA_TB/schematic, simulator spectre
    Outputs: /Carry_OUT; /SUM; /Carry_IN; /B; /A
