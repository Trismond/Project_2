ADE simulation setup
Run mode: Single Run, Sweeps and Corners
Tests:
  Project_2_ALU_FINAL_TB_1: Project_2/ALU_FINAL_TB/schematic, simulator spectre
    Outputs: /OUT; /OUT3; /OUT2; /OUT1; /OUT0; /A1; /A0; /B1; /B0; /S2; /S1; /S0
