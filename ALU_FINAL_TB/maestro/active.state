ADE simulation setup
Test Project_2_ALU_FINAL_TB_1: Project_2/ALU_FINAL_TB/schematic, simulator spectre
  Models: /opt/pdk/gpdk045/gpdk045_v_6_0/gpdk045/../models/spectre/gpdk045.scs[mc]
  Temperature: 27
  Analysis tran: stop=640n
  Signals: /OUT3, /OUT2, /OUT1, /OUT0, /A1, /A0, /B1, /B0, /S2, /S1, /S0
Run mode: Single Run, Sweeps and Corners
