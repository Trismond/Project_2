ADE simulation setup
Test Project_2_MUX_TB_1: Project_2/MUX_TB/schematic, simulator spectre
  Models: /opt/pdk/gpdk045/gpdk045_v_6_0/gpdk045/../models/spectre/gpdk045.scs[mc]
  Temperature: 27
  Analysis tran: stop=80n
  Signals: /ALU_Control_2, /ALU_Control_1, /ALU_Control_0, /Select7, /Select6, /Select5, /Select4, /Select3, /Select2, /Select1, /Select0
Run mode: Single Run, Sweeps and Corners
