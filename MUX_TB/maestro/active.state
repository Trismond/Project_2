ADE simulation setup
Test Project_2_MUX_TB_1: Project_2/MUX_TB/schematic, simulator spectre
  Models: /opt/pdk/gpdk045/gpdk045_v_6_0/gpdk045/../models/spectre/gpdk045.scs[mc]
  Temperature: 27
  Analysis tran: stop=320n
  Signals: /OUT, /EA, /A, /EM, /EX, /EAND, /EO, /EN
Run mode: Single Run, Sweeps and Corners
