ADE simulation setup
Run mode: Single Run, Sweeps and Corners
Tests:
  Project_2_MUX_TB_1: Project_2/MUX_TB/schematic, simulator spectre
    Outputs: /OUT; "/EA"; /EA; /A; /EM; /EX; /EAND; /EO; /EN
