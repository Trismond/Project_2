ADE simulation setup
Test Project_2_3_NOR_TB_1: Project_2/3_NOR_TB/schematic, simulator spectre
  Models: /opt/pdk/gpdk045/gpdk045_v_6_0/gpdk045/../models/spectre/gpdk045.scs[mc]
  Temperature: 27
  Analysis tran: stop=80n
  Signals: /OUT, /A, /B, /C
Run mode: Single Run, Sweeps and Corners
