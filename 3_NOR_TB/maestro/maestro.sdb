ADE simulation setup
Run mode: Single Run, Sweeps and Corners
Tests:
  Project_2_3_NOR_TB_1: Project_2/3_NOR_TB/schematic, simulator spectre
    Outputs: /OUT; /A; /B; /C
