ADE simulation setup
Run mode: Single Run, Sweeps and Corners
Tests:
  Project_2_MUX_TB_1: Project_2/EN_TB/schematic, simulator spectre
    Outputs: /; "/S2"; /S2; /S1; /S0; "/ADD_SUB"; /ADD_SUB; /MUL; /XOR; /AND; /OR; /NOT
