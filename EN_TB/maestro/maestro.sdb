ADE simulation setup
Run mode: Single Run, Sweeps and Corners
Tests:
  Project_2_MUX_TB_1: Project_2/EN_TB/schematic, simulator spectre
