ADE simulation setup
Test Project_2_MUX_TB_1: Project_2/EN_TB/schematic, simulator spectre
  Models: /opt/pdk/gpdk045/gpdk045_v_6_0/gpdk045/../models/spectre/gpdk045.scs[mc]
  Temperature: 27
  Analysis tran: stop=80n
  Signals: /S2, /S1, /S0, /ADD_SUB, /MUL, /XOR, /AND, /OR, /NOT
Run mode: Single Run, Sweeps and Corners
