ADE simulation setup
Run mode: Single Run, Sweeps and Corners
Tests:
  Project_2_AND_TB_1: Project_2/AND_TB/schematic, simulator spectre
    Outputs: /OUT; /A; /B
