ADE simulation setup
Run mode: Single Run, Sweeps and Corners
Tests:
  Project_2_OR_TB_1: Project_2/OR_TB/schematic, simulator spectre
    Outputs: /Out; /In_A; /In_B
