ADE simulation setup
Run mode: Single Run, Sweeps and Corners
Tests:
  Project_1_NAND_TB_1: Project_1/NAND_TB/schematic, simulator spectre
