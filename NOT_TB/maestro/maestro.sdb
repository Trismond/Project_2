ADE simulation setup
Run mode: Single Run, Sweeps and Corners
Tests:
  Project_2_NOT_TB_1: Project_2/NOT_TB/schematic, simulator spectre
    Outputs: /OUT; /IN
