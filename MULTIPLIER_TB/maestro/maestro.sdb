ADE simulation setup
Run mode: Single Run, Sweeps and Corners
Tests:
  Project_2_MULTIPLIER_TB_1: Project_2/MULTIPLIER_TB/schematic, simulator spectre
